// SystemRDL 2.0 description of the Microchip AT86RF215 dual-band sub-GHz /
// 2.4 GHz radio transceiver.
//
// Single source of truth for the AT86RF215 QEMU device model and its
// conformance tests. Every numeric value in this file must trace to an
// exact datasheet citation in a comment.
//
// Datasheet: Atmel-42415E-WIRELESS-RF215, 05/2016.
// See ../SOURCES.md for URL and sha256.
//
// Format rationale: SystemRDL is the Accellera-blessed register description
// language and is recommended by the DVCon survey paper "Comprehensive
// Register Description Languages" (Black & Smith, Doulos) as the closest
// available standard for CSR authoring. Tooling: PeakRDL (Apache/LGPL,
// actively maintained).
//
// SPDX-License-Identifier: GPL-2.0-or-later

addrmap at86rf215 {
    name = "AT86RF215";
    desc = "Dual-band sub-GHz / 2.4 GHz IEEE 802.15.4 radio transceiver";

    default regwidth = 8;
    default accesswidth = 8;

    // Datasheet section 1.1.3.1 "RF_PN - Device Part Number", page 4.
    // Bit layout table: (0x000D) PN[7:0], all bits R.
    //
    // Datasheet section 1.1.3.1 sub-register table, page 4:
    //   0x34 = AT86RF215   (dual-band)
    //   0x35 = AT86RF215IQ (I/Q interface variant)
    //   0x36 = AT86RF215M  (sub-GHz only). NOTE: erratum #9 (section 15.2.9):
    //                       actual silicon returns 0x34 instead of 0x36.
    enum PN_e {
        AT86RF215   = 8'h34 { desc = "AT86RF215 (dual-band)"; };
        AT86RF215IQ = 8'h35 { desc = "AT86RF215IQ (I/Q interface variant)"; };
        AT86RF215M  = 8'h36 { desc = "AT86RF215M (sub-GHz only, errata #9)"; };
    };

    reg {
        name = "RF_PN";
        desc = "Device Part Number";

        field {
            name = "PN";
            desc = "Device Part Number";
            sw = r; hw = r;
            encode = PN_e;
            reset = 8'h34;
        } PN[7:0];
    } RF_PN @ 0x000D;
};
